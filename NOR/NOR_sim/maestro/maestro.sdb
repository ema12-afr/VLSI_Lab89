ADE simulation setup
Run mode: Single Run, Sweeps and Corners
Tests:
  ema_89_NOR_sim_1: ema_89/NOR_sim/schematic, simulator spectre
    Outputs: /Vout; /Va; /Vb
