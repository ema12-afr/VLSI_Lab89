ADE simulation setup
Test ema_89_NOR_sim_1: ema_89/NOR_sim/schematic, simulator spectre
  Models: /home/cadence/tech/gpdk045_v_6_0/gpdk045/../models/spectre/gpdk045.scs[mc]
  Temperature: 27
  Analysis dc: sweep /PORT0.dc start=0 stop=1.8
  Signals: /Vout, /Va, /Vb
Run mode: Single Run, Sweeps and Corners
